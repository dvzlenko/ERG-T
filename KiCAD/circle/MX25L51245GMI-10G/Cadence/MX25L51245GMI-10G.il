defun( AFn_OpenDesign (@key design, (mode "w"), noMru, noConfirm, forceNew)
 let((noconfirmStatus, result)
  when(noConfirm, noconfirmStatus = axlGetVariable("NOCONFIRM"), axlSetVariable("NOCONFIRM", t))
  when(forceNew && isFile(design), deleteFile(design))
  result = if(noMru && axlVersion('version) >= 16.0
   then axlOpenDesign(?design design, ?mode mode, ?noMru t)
   else axlOpenDesign(?design design, ?mode mode)
  )
  when(noConfirm, if(noconfirmStatus then axlSetVariable("NOCONFIRM", t) else axlUnsetVariable("NOCONFIRM")))
  result
))
procedure( CreatePadstacks()
    axlDBChangeDesignUnits("millimeters" 4)
    pad_list0 = cons(make_axlPadStackPad(
        ?layer "TOP", ?type 'REGULAR,
        ?figure 'RECTANGLE, ?figureSize 0.65:1.87) nil)
    ps_id = axlDBCreatePadStack("r187_65", nil, pad_list0 t)
    axlPadstackToDisk("r187_65")
)
procedure( BuildFootprint()
    AFn_OpenDesign(?design strcat("SOIC127P1030X265-16N", ".dra"), ?mode "wf", ?noMru t, ?noConfirm t, ?forceNew t)
    axlSetSymbolType("package")
    mytext = make_axlTextOrientation(?textBlock 6, ?rotation 0, ?mirrored nil, ?justify "center")
    mypin = make_axlPinText(?number "1", ?offset 0:0, ?text mytext)
    axlDBCreatePin("r187_65" 95.31:104.445 mypin 90)
    mypin = make_axlPinText(?number "2", ?offset 0:0, ?text mytext)
    axlDBCreatePin("r187_65" 95.31:103.175 mypin 90)
    mypin = make_axlPinText(?number "3", ?offset 0:0, ?text mytext)
    axlDBCreatePin("r187_65" 95.31:101.905 mypin 90)
    mypin = make_axlPinText(?number "4", ?offset 0:0, ?text mytext)
    axlDBCreatePin("r187_65" 95.31:100.635 mypin 90)
    mypin = make_axlPinText(?number "5", ?offset 0:0, ?text mytext)
    axlDBCreatePin("r187_65" 95.31:99.365 mypin 90)
    mypin = make_axlPinText(?number "6", ?offset 0:0, ?text mytext)
    axlDBCreatePin("r187_65" 95.31:98.095 mypin 90)
    mypin = make_axlPinText(?number "7", ?offset 0:0, ?text mytext)
    axlDBCreatePin("r187_65" 95.31:96.825 mypin 90)
    mypin = make_axlPinText(?number "8", ?offset 0:0, ?text mytext)
    axlDBCreatePin("r187_65" 95.31:95.555 mypin 90)
    mypin = make_axlPinText(?number "9", ?offset 0:0, ?text mytext)
    axlDBCreatePin("r187_65" 104.69:95.555 mypin 90)
    mypin = make_axlPinText(?number "10", ?offset 0:0, ?text mytext)
    axlDBCreatePin("r187_65" 104.69:96.825 mypin 90)
    mypin = make_axlPinText(?number "11", ?offset 0:0, ?text mytext)
    axlDBCreatePin("r187_65" 104.69:98.095 mypin 90)
    mypin = make_axlPinText(?number "12", ?offset 0:0, ?text mytext)
    axlDBCreatePin("r187_65" 104.69:99.365 mypin 90)
    mypin = make_axlPinText(?number "13", ?offset 0:0, ?text mytext)
    axlDBCreatePin("r187_65" 104.69:100.635 mypin 90)
    mypin = make_axlPinText(?number "14", ?offset 0:0, ?text mytext)
    axlDBCreatePin("r187_65" 104.69:101.905 mypin 90)
    mypin = make_axlPinText(?number "15", ?offset 0:0, ?text mytext)
    axlDBCreatePin("r187_65" 104.69:103.175 mypin 90)
    mypin = make_axlPinText(?number "16", ?offset 0:0, ?text mytext)
    axlDBCreatePin("r187_65" 104.69:104.445 mypin 90)
    axlDBCreateText("Q*" 100:100 "2" "REF DES/SILKSCREEN_TOP")
    axlDBCreateLine((list 94.125:105.5 105.875:105.5), 0.05, "PACKAGE GEOMETRY/PLACE_BOUND_TOP")
    axlDBCreateLine((list 105.875:105.5 105.875:94.5), 0.05, "PACKAGE GEOMETRY/PLACE_BOUND_TOP")
    axlDBCreateLine((list 105.875:94.5 94.125:94.5), 0.05, "PACKAGE GEOMETRY/PLACE_BOUND_TOP")
    axlDBCreateLine((list 94.125:94.5 94.125:105.5), 0.05, "PACKAGE GEOMETRY/PLACE_BOUND_TOP")
    axlDBCreateLine((list 96.245:105.15 103.755:105.15), 0.1, "PACKAGE GEOMETRY/ASSEMBLY_TOP")
    axlDBCreateLine((list 103.755:105.15 103.755:94.85), 0.1, "PACKAGE GEOMETRY/ASSEMBLY_TOP")
    axlDBCreateLine((list 103.755:94.85 96.245:94.85), 0.1, "PACKAGE GEOMETRY/ASSEMBLY_TOP")
    axlDBCreateLine((list 96.245:94.85 96.245:105.15), 0.1, "PACKAGE GEOMETRY/ASSEMBLY_TOP")
    axlDBCreateLine((list 96.245:103.88 97.515:105.15), 0.1, "PACKAGE GEOMETRY/ASSEMBLY_TOP")
    axlDBCreateLine((list 96.595:105.15 103.405:105.15), 0.2, "PACKAGE GEOMETRY/SILKSCREEN_TOP")
    axlDBCreateLine((list 103.405:105.15 103.405:94.85), 0.2, "PACKAGE GEOMETRY/SILKSCREEN_TOP")
    axlDBCreateLine((list 103.405:94.85 96.595:94.85), 0.2, "PACKAGE GEOMETRY/SILKSCREEN_TOP")
    axlDBCreateLine((list 96.595:94.85 96.595:105.15), 0.2, "PACKAGE GEOMETRY/SILKSCREEN_TOP")
    axlDBCreateLine((list 94.375:105.12 96.245:105.12), 0.2, "PACKAGE GEOMETRY/SILKSCREEN_TOP")
    ;axlCompileSymbol(?symbol "SOIC127P1030X265-16N", ?type "package")
    axlSaveDesign(?noMru t)
)
